# Ansys Electronics Desktop project, version 2018.2
materials:
  vacuum: permittivity=1
  ferrite: permittivity=12 permeability=1000 conductivity=0.01
  copper: permeability=0.999991 conductivity=58000000
  steel_1010: permittivity=1 permeability{BType=normal HUnit=A_per_meter BUnit=tesla curve (0, 0) (238.7, 0.2003) (318.3, 0.3204) (358.1, 0.40045) (437.7, 0.50055) (477.5, 0.5606) (636.6, 0.7908) (795.8, 0.931) (1114.1, 1.1014) (1273.2, 1.2016) (1591.5, 1.302) (2228.2, 1.4028) (3183.1, 1.524) (4774.6, 1.626) (6366.2, 1.698) (7957.7, 1.73) (15915.5, 1.87) (31831, 1.99) (47746.5, 2.04) (63662, 2.07) (79577.5, 2.095) (159155, 2.2) (318310, 2.4)} conductivity=2000000 lande_g_factor=2
  cobalt: permeability=250 conductivity=10000000
  iron: permeability=4000 conductivity=10300000

design Maxwell3DDesign1 (Maxwell 3D, Transient, model units mm)
options: Multiplier=1
variables:
  rot_angle = 45deg
  Mag = 1A
geometry:
  Core_main [cobalt] = box(corner=(0mm, 0mm, 0mm), size=(20mm, 60mm, 70mm))
  window = box(corner=(0mm, 15mm, 15mm), size=(20mm, 30mm, 40mm))
  Core_main.subtract(window)
  Rotor_gap = cylinder(axis=X, base_centre=(0mm, 52.5mm, 35mm), radius=12.5mm, height=20mm)
  Rotor_main = cylinder(axis=X, base_centre=(0mm, 52.5mm, 35mm), radius=12mm, height=20mm)
  Core_main.subtract(Rotor_gap)
  Box1 = box(corner=(0mm, 45mm, 25mm), size=(20mm, -10mm, 20mm))
  Box2 = box(corner=(0mm, 60mm, 25mm), size=(20mm, 10mm, 20mm))
  Rotor_main.subtract(Box1, Box2)
  Rotor_add [cobalt] = cylinder(axis=X, base_centre=(0mm, 52.5mm, 35mm), radius=10mm, height=20mm)
  Rotor_add.unite(Rotor_main)
  Winding [copper] = rectangle(corner=(10mm, 15mm, 20mm), y_size=10mm, z_size=30mm)
  Path = rectangle(corner=(-5mm, 20mm, 35mm), x_size=30mm, y_size=-25mm, uncovered)
  Winding.sweep_along_path(Path)
  [Rotor_add, Core_main, Winding].move(-10mm, -52.5mm, -35mm)
  Rotor_add.rotate(axis=X, angle=rot_angle)
  Cur [copper] = Winding.section(plane=YZ)
  Cur.separate_bodies()
  Region [vacuum] = region(percentage_offset=400 on all sides)
  Torque [vacuum] = cylinder(axis=X, base_centre=(-15mm, 0mm, 0mm), radius=12.25mm, height=30mm)
motion:
  MotionSetup1: Band Move_Type=Rotate Coordinate_System=Global Axis=X Is_Positive=true InitPos=45deg Angular_Velocity=0rpm Moment_of_Inertia=0.0001 Damping=0 Load_Torque=0NewtonMeter Objects=Torque
  Moving1: Moving Objects=Rotor_add
boundaries and excitations:
  Insulating1: Insulating Objects=Winding
  CoilTerminal1: Coil Terminal Objects=Cur Conductor_number=250 Winding=Winding1 Point_out_of_terminal=false
  Winding1: Winding Group Type=Current IsSolid=false Current=3A ParallelBranchesNum=1
  eddy effects on: Core_main, Rotor_add, Winding
mesh:
  CylindricalGap1: CylindricalGap Objects=Torque
  SurfApprox1: SurfApproxBased Objects=[Core_main, Rotor_add, Winding] CurvedSurfaceApproxChoice=UseSlider SliderMeshSettings=8
  Length1: LengthBased RefineInside Objects=[Rotor_add, Core_main, Winding] MaxLength=5mm
  initial mesh: GlobalCurvilinear{Apply}
setups:
  Setup1: Transient NonlinearSolverResidual=0.005 ScalarPotential="Second Order" StopTime=0.5s TimeStep=0.01s SweepSetupType=LinearStep StartValue=0ns StopValue=10000000ns StepSize=5000000ns
optimetrics:
  ParametricSetup1: Parametric Sim._Setups=[Setup1]
    sweep rot_angle: LIN -45deg 45deg 45deg
field plots:
  B_Vector1: B over Rotor_add on Setup1 : Transient at Time=-1
  B_Vector2: B over Rotor_add on Setup1 : Transient at Time=1s
